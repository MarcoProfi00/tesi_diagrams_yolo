.title ic03 timing resistor comparison with official TI LM317 model

.include "extracted/LM317_TRANS.LIB"

* Base: R1=R2=R3=10k
VB IN_B 0 DC 12
XB IN_B ADJ_B OUT_B OUT_B LM317_TRANS
RLB OUT_B 0 12
CB1 IN_B 0 2.2u
CB2 OUT_B ADJ_B 10u
CB3 OUT_B MID1_B 10u
CB4 OUT_B MID2_B 10u
RB1 ADJ_B MID1_B 10k
RB2 MID1_B MID2_B 10k
RB3 MID2_B 0 10k

* R1 increased to 22k
V1 IN_1 0 DC 12
X1 IN_1 ADJ_1 OUT_1 OUT_1 LM317_TRANS
RL1 OUT_1 0 12
C11 IN_1 0 2.2u
C12 OUT_1 ADJ_1 10u
C13 OUT_1 MID1_1 10u
C14 OUT_1 MID2_1 10u
R11 ADJ_1 MID1_1 22k
R12 MID1_1 MID2_1 10k
R13 MID2_1 0 10k

* R2 increased to 22k
V2 IN_2 0 DC 12
X2 IN_2 ADJ_2 OUT_2 OUT_2 LM317_TRANS
RL2 OUT_2 0 12
C21 IN_2 0 2.2u
C22 OUT_2 ADJ_2 10u
C23 OUT_2 MID1_2 10u
C24 OUT_2 MID2_2 10u
R21 ADJ_2 MID1_2 10k
R22 MID1_2 MID2_2 22k
R23 MID2_2 0 10k

* R3 increased to 22k
V3 IN_3 0 DC 12
X3 IN_3 ADJ_3 OUT_3 OUT_3 LM317_TRANS
RL3 OUT_3 0 12
C31 IN_3 0 2.2u
C32 OUT_3 ADJ_3 10u
C33 OUT_3 MID1_3 10u
C34 OUT_3 MID2_3 10u
R31 ADJ_3 MID1_3 10k
R32 MID1_3 MID2_3 10k
R33 MID2_3 0 22k

* R1 increased to 33k
V4 IN_4 0 12
X4 IN_4 ADJ_4 OUT_4 OUT_4 LM317_TRANS
RL4 OUT_4 0 12
C41 IN_4 0 2.2u
C42 OUT_4 ADJ_4 10u
C43 OUT_4 MID1_4 10u
C44 OUT_4 MID2_4 10u
R41 ADJ_4 MID1_4 33k
R42 MID1_4 MID2_4 10k
R43 MID2_4 0 10k

.save all
.tran 2ms 30s

.control
set wr_singlescale
set wr_vecnames
run
wrdata ic03_resistor_sweep.csv time v(OUT_B) v(OUT_1) v(OUT_2) v(OUT_3) v(OUT_4)
.endc
.end
