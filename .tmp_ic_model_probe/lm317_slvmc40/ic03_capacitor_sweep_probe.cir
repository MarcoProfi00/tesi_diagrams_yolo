.title ic03 timing capacitor comparison with official TI LM317 model
.include "extracted/LM317_TRANS.LIB"

* Base: C2=C3=C4=10u
VB IN_B 0 12
XB IN_B ADJ_B OUT_B OUT_B LM317_TRANS
RLB OUT_B 0 12
C1B IN_B 0 2.2u
C2B OUT_B ADJ_B 10u
C3B OUT_B MID1_B 10u
C4B OUT_B MID2_B 10u
R1B ADJ_B MID1_B 10k
R2B MID1_B MID2_B 10k
R3B MID2_B 0 10k

* C2 between output and ADJ increased to 22u
V1 IN_1 0 12
X1 IN_1 ADJ_1 OUT_1 OUT_1 LM317_TRANS
RL1 OUT_1 0 12
C11 IN_1 0 2.2u
C12 OUT_1 ADJ_1 22u
C13 OUT_1 MID1_1 10u
C14 OUT_1 MID2_1 10u
R11 ADJ_1 MID1_1 10k
R12 MID1_1 MID2_1 10k
R13 MID2_1 0 10k

* C3 between output and MID1 increased to 22u
V2 IN_2 0 12
X2 IN_2 ADJ_2 OUT_2 OUT_2 LM317_TRANS
RL2 OUT_2 0 12
C21 IN_2 0 2.2u
C22 OUT_2 ADJ_2 10u
C23 OUT_2 MID1_2 22u
C24 OUT_2 MID2_2 10u
R21 ADJ_2 MID1_2 10k
R22 MID1_2 MID2_2 10k
R23 MID2_2 0 10k

* C4 between output and MID2 increased to 22u
V3 IN_3 0 12
X3 IN_3 ADJ_3 OUT_3 OUT_3 LM317_TRANS
RL3 OUT_3 0 12
C31 IN_3 0 2.2u
C32 OUT_3 ADJ_3 10u
C33 OUT_3 MID1_3 10u
C34 OUT_3 MID2_3 22u
R31 ADJ_3 MID1_3 10k
R32 MID1_3 MID2_3 10k
R33 MID2_3 0 10k

.tran 2ms 30s
.control
set wr_singlescale
set wr_vecnames
run
wrdata ic03_capacitor_sweep.csv time v(OUT_B) v(OUT_1) v(OUT_2) v(OUT_3)
.endc
.end
