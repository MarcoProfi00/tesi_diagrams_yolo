* Standalone ngspice probe for the official TI TLC555 PSpice Rev. E model.
.include pspice_rev_e/TLC555_6.LIB

VVCC vcc 0 DC 9
R1 vcc disc 1k
R2 disc timing 1k
C1 timing 0 1u
C2 control 0 1u
C3 vcc 0 1u
R3 out led_anode 1k
DLED led_anode 0 LED_RED
.model LED_RED D

* TI port order: THRES CONT TRIG RESET OUT DISC VCC GND
XTIMER timing control timing vcc out disc vcc 0 TLC555_6

.tran 5u 100m

.control
set wr_singlescale
set wr_vecnames
run
wrdata test_pspice_ic01.csv time v(out) v(timing) v(disc) v(control)
.endc

.end
