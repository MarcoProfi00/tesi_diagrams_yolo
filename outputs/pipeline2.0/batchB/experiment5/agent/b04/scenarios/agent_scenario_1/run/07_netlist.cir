* pipeline2.0 netlist
* circuit: b04

VVBAT_TEST N009 0 DC 12
VVREF_BATTERY_NEGATIVE N010 0 DC 0
Ddiode7_1 N001 N002 D_1N4001_TYP
Xdiode7_2 N003 H1_GATE N004 SCR_2N3668_TYP
Ddiode7_3 N001 H1_GATE D_1N4001_TYP
Ddiode7_4 N005 N004 D_1N4001_TYP
Ddiode7_5 N006 N007 D_GENERIC
Rfuse8_1 N008 N009 1m
Qnpn_transistor18_1 N002 N007 N010 BC148_TYP
Rresistor22_1 N003 N005 22
Rresistor22_2 N003 N001 330
Rresistor22_3 N004 N011 820
Rresistor22_4 N006 N010 100
Rresistor22_5 N011 N006 100
Rresistor22_6 N004 N008 1
Vtransformer28_1 N003 N010 SIN(0 21.2132 50)

.model BC148_TYP NPN(BF=110 VAF=50 IKF=100m IS=1e-14)
.model D_1N4001_TYP D(IS=14n N=1.9 RS=0.08 BV=50 IBV=5u TT=2u CJO=25p)
.model D_GENERIC D
.subckt SCR_2N3668_TYP A G K
BMAIN A K I={V(A,K)*(1/10Meg+(1/0.05-1/10Meg)*(0.5+0.5*tanh((V(G,K)-0.75)/0.08)))}
RGK G K 100
.ends SCR_2N3668_TYP

.op
.save all
.tran 100us 100ms

.control
set wr_singlescale
set wr_vecnames
save all @ddiode7_1[id] @ddiode7_3[id] @ddiode7_4[id] @ddiode7_5[id]
run
wrdata 08_tran.csv time v(H1_GATE) v(N001) v(N002) v(N003) v(N004) v(N005) v(N006) v(N007) v(N008) v(N009) v(N010) v(N011) @ddiode7_1[id] @ddiode7_3[id] @ddiode7_4[id] @ddiode7_5[id]
.endc
.end
