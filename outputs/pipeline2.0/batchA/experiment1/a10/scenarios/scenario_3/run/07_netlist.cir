* pipeline2.0 netlist
* circuit: a10

Vbattery2_1 N001 0 DC 5
Rlamp13_1 N004 0 250
Dled12_1 N005 0 LED_RED
Rresistor22_1 N003 N005 330
* switch25.1 open: not emitted

.model LED_RED D

VSCENARIO_N003 N003 0 DC 5
.op
.end
