* pipeline2.0 netlist
* circuit: a01

VVCC N001 0 DC 5
Rlamp13_1 N004 0 50
Dled12_1 N005 0 LED_RED
Rresistor22_1 N002 N004 1000
Rresistor22_2 N001 N005 220
* switch25.1 open in base run; closed by scenario close_switch

.model LED_RED D

* scenario close_switch: switch25.1 modeled as RSCENARIO_switch25_1 0 N003 1m
RSCENARIO_switch25_1 0 N003 1m
.op
.end
