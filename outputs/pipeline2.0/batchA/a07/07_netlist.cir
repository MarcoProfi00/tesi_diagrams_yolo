* pipeline2.0 netlist
* circuit: a07

Rmeter_analog_meter0_1 N001 0 10000000
Rresistor22_1 N003 0 680
* switch25.1 open: not emitted
Vtransformer28_1 N002 N001 SIN(0 16.9706 50)

.op
.save all
.tran 0.1ms 40ms

.control
set wr_singlescale
set wr_vecnames
run
wrdata 08_tran.csv time v(N001) v(N002) v(N003)
.endc
.end
