* pipeline2.0 netlist
* circuit: a02

Vbattery2_1 N002 N001 DC 5
Ccapacitor4_1 N003 0 100n
Rresistor22_1 N001 N004 10000
* switch25.1 open: not emitted

.op
.end
