* pipeline2.0 netlist
* circuit: a09

Vbattery2_1 N001 0 DC 9
Ccapacitor4_1 N002 0 100n
Rfuse8_1 N001 N003 1m
Rlamp13_1 N006 0 90
Dled12_1 N007 0 LED_RED
Rresistor22_1 N005 N007 330
* switch25.1 open in base run; closed by scenario close_switch

.model LED_RED D

* scenario close_switch: switch25.1 modeled as RSCENARIO_switch25_1 N004 N006 1m
RSCENARIO_switch25_1 N004 N006 1m
RSCENARIO_CONNECT_N003_N004 N003 N004 1m
RSCENARIO_CONNECT_N003_N005 N003 N005 1m
.op
.end
