* pipeline2.0 netlist
* circuit: a05

Ccapacitor4_1 N002 0 47n
Rresistor22_1 N003 N001 1000
* switch25.1 open: not emitted

.op
.end
