* pipeline2.0 netlist
* circuit: a10

Vbattery2_1 N001 0 DC 5
Rlamp13_1 N004 0 250
Dled12_1 N005 0 LED_RED
Rresistor22_1 N003 N005 330
* switch25.1 open in base run; closed by scenario close_switch

.model LED_RED D

* scenario close_switch: switch25.1 modeled as RSCENARIO_switch25_1 N001 N002 1m
RSCENARIO_switch25_1 N001 N002 1m
RSCENARIO_CONNECT_N002_N004 N002 N004 1m
.op
.end
