* pipeline2.0 netlist
* circuit: a05

Ccapacitor4_1 N002 0 47n
Rresistor22_1 N003 N001 1000
* switch25.1 open in base run; closed by scenario close_switch

VSCENARIO_SUPPLY_N003_0 N003 0 DC 5
* scenario close_switch: switch25.1 modeled as RSCENARIO_switch25_1 0 N004 1m
RSCENARIO_switch25_1 0 N004 1m
.op
.end
