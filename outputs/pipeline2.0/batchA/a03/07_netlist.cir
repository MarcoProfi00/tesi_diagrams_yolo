* pipeline2.0 netlist
* circuit: a03

Vbattery2_1 N002 N001 DC 12
Vbattery2_2 N004 N003 DC 12
Dled12_1 N005 N002 LED_RED
Qnpn_transistor18_1 N009 N008 N003 BC547
Qnpn_transistor18_2 N005 N009 N003 BC547
Rresistor22_1 N008 N003 100k
Rresistor22_2 N002 N009 1k
Vsignal_source23_1 N010 N006 AC 220
Rswitch25_1 N011 N007 1m

.model BC547 NPN
.model LED_RED D

.op
.end
