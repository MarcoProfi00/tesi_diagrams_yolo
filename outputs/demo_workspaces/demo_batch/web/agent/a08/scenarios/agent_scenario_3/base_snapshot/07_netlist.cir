* pipeline2.0 netlist
* circuit: a08

Ccapacitor4_1 N001 0 10u
Dled12_1 N002 N003 LED_RED
Qnpn_transistor18_1 N003 N004 N005 2N3904
Rresistor22_1 N002 N001 10k
Rresistor22_2 N005 0 560
Rresistor22_3 N002 N005 560
Rresistor22_4 N001 N004 68k
Vsignal_source23_1 N002 0 PULSE(0 5 0 1ms 1ms 50ms 100ms)

.model 2N3904 NPN(IS=6.734f BF=416.4 VAF=74.03 IKF=66.78m ISE=6.734f NE=1.259 BR=0.7371 VAR=12.11 IKR=0.0 ISC=0.0 NC=2 RB=10 RC=1 RE=0.1 CJE=4.493p VJE=0.75 MJE=0.2593 CJC=3.638p VJC=0.75 MJC=0.3085 TF=301.2p TR=239.5n)
.model LED_RED D

.op
.save all
.tran 0.5ms 300ms

.control
set wr_singlescale
set wr_vecnames
save all @dled12_1[id]
run
wrdata 08_tran.csv time v(N001) v(N002) v(N003) v(N004) v(N005) @dled12_1[id]
.endc
.end
