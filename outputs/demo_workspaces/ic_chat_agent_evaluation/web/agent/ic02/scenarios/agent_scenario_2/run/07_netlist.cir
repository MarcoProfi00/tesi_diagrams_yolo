* pipeline2.0 netlist
* circuit: ic02

VAUDIO_IN N011 0 SIN(0 0.02 1000)
VVCC_25 N004 0 DC 25
VVEE_N25 N002 0 DC -25
Rfuse8_1 N001 N002 1m
Rfuse8_2 N003 N004 1m
Xintegrated_circuit11_1 N006 N005 N001 N003 N007 LM1875_0
Cpolarized_capacitor20_1 N005 N008 1u
Cpolarized_capacitor20_2 N009 0 22u
Cpolarized_capacitor20_3 N001 0 100n
Cpolarized_capacitor20_4 N003 0 100n
Cpolarized_capacitor20_5 N001 0 220u
Cpolarized_capacitor20_6 N003 0 220u
Cpolarized_capacitor20_7 N010 0 0.22u
Rresistor22_1 N011 N008 1k
Rresistor22_2 N008 0 1meg
Rresistor22_3 N005 0 22k
Rresistor22_4 N006 N009 4.7k
Rresistor22_5 N006 N007 180k
Rresistor22_6 N007 N010 1
Rspeaker24_1 N007 0 4

.include "07_external_models.lib"

.op
.save all
.tran 10us 20ms

.control
set wr_singlescale
set wr_vecnames
run
wrdata 08_tran.csv time v(N001) v(N002) v(N003) v(N004) v(N005) v(N006) v(N007) v(N008) v(N009) v(N010) v(N011)
.endc
.end
