* pipeline2.0 netlist
* circuit: a09

Vbattery2_1 N001 0 DC 9
Ccapacitor4_1 N002 0 100n
Rfuse8_1 N001 N003 1m
Rlamp13_1 N005 N006 90
Dled12_1 N007 0 LED_RED
Rresistor22_1 0 N007 330
* switch25.1 open: not emitted

.model LED_RED D

.op
.end
