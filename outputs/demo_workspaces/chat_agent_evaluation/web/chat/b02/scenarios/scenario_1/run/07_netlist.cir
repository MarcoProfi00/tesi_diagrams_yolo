* pipeline2.0 netlist
* circuit: b02

VVCC N001 0 DC 5
Dled12_1 N001 N002 LED_RED
Dled12_2 N001 N003 LED_RED
Qnpn_transistor18_1 N005 N004 0 2N3904
Qnpn_transistor18_2 N007 N006 0 2N3904
Cpolarized_capacitor20_1 N005 N006 47u
Cpolarized_capacitor20_2 N007 N004 47u
Rresistor22_1 N002 N005 270
Rresistor22_2 N001 N004 2.2k
Rresistor22_3 N001 N006 2.2k
Rresistor22_4 N003 N007 270

.model 2N3904 NPN(IS=6.734f BF=416.4 VAF=74.03 IKF=66.78m ISE=6.734f NE=1.259 BR=0.7371 VAR=12.11 IKR=0.0 ISC=0.0 NC=2 RB=10 RC=1 RE=0.1 CJE=4.493p VJE=0.75 MJE=0.2593 CJC=3.638p VJC=0.75 MJC=0.3085 TF=301.2p TR=239.5n)
.model LED_RED D

* pipeline2 scenario initial conditions
.ic V(N004)=0.6 V(N006)=1.0
.op
.save all
.tran 1ms 1s UIC

.control
set wr_singlescale
set wr_vecnames
save all @dled12_1[id] @dled12_2[id]
run
wrdata 08_tran.csv time v(N001) v(N002) v(N003) v(N004) v(N005) v(N006) v(N007) @dled12_1[id] @dled12_2[id]
.endc
.end
