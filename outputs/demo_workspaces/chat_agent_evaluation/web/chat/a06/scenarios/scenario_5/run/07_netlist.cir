* pipeline2.0 netlist
* circuit: a06

VVCC N007 0 DC 12
VVEE N008 0 DC 0
Ccapacitor4_1 N001 N002 1u
Ccapacitor4_2 N003 0 100u
Ccapacitor4_3 N004 N005 10u
Qnpn_transistor18_1 N004 N002 N003 2N2222
Rresistor22_1 N006 N001 1k
Rresistor22_2 N007 N002 100k
Rresistor22_3 N002 0 47k
Rresistor22_4 N007 N004 6.8k
Rresistor22_5 N003 N008 3.9k
Rresistor22_6 N005 0 10k
Vsignal_source23_1 N006 0 SIN(0 20m 100)

.model 2N2222 NPN(IS=14.34f BF=255.9 VAF=74.03 IKF=0.2847 ISE=14.34f NE=1.307 BR=6.092 NR=1.005 VAR=11.96 IKR=0.0 ISC=0.0 NC=2 RB=10 RC=1 RE=0.1 CJE=22.01p VJE=0.75 MJE=0.377 CJC=7.306p VJC=0.75 MJC=0.3416 TF=411.1p TR=46.91n)

.op
.save all
.tran 0.1ms 50ms

.control
set wr_singlescale
set wr_vecnames
run
wrdata 08_tran.csv time v(N001) v(N002) v(N003) v(N004) v(N005) v(N006) v(N007) v(N008)
.endc
.end
