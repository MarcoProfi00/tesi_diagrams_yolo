* pipeline2.0 netlist
* circuit: c03

VAUDIO_IN N005 0 SIN(0 0.2 1000)
VVCC_18 N001 0 DC 18
Xoperational_amplifier19_1 N002 N003 N001 0 N004 TDA2003_SIMPLE
Cpolarized_capacitor20_1 N002 N005 10u
Cpolarized_capacitor20_2 N003 N006 470u
Cpolarized_capacitor20_3 N001 0 1000u
Cpolarized_capacitor20_4 N004 N007 39n
Cpolarized_capacitor20_5 N001 0 100n
Cpolarized_capacitor20_6 N004 N008 1000u
Cpolarized_capacitor20_7 N008 N009 100n
Rresistor22_1 N007 N003 39
Rresistor22_2 N006 0 2.2
Rresistor22_3 N004 N006 220
Rresistor22_4 N009 0 1
Rspeaker24_1 N008 0 4

.subckt TDA2003_SIMPLE INP INM VCC VEE OUT
EREF VREF VEE VCC VEE 0.5
RINP INP VREF 1Meg
RINM INM VREF 1Meg
BAMP NAMP VEE V={0.75+(V(VCC,VEE)-1.5)*(0.5+0.5*tanh((100000*V(INP,INM))/(0.5*(V(VCC,VEE)-1.5))))}
ROUT NAMP OUT 0.2
RBLEED VCC VEE 100k
.ends TDA2003_SIMPLE

.op
.save all
.tran 10us 20ms

.control
set wr_singlescale
set wr_vecnames
run
wrdata 08_tran.csv time v(N001) v(N002) v(N003) v(N004) v(N005) v(N006) v(N007) v(N008) v(N009)
.endc
.end
