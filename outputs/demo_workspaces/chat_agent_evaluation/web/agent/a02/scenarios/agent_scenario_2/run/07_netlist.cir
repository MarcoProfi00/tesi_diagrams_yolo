* pipeline2.0 netlist
* circuit: a02

Vbattery2_1 N002 N001 DC 5
Ccapacitor4_1 N003 0 100n
Rresistor22_1 N001 N004 10000
* switch25.1 open in base run; closed by scenario close_switch

RSCENARIO_CONNECT_N004_N002 N004 N002 1m
* scenario close_switch: switch25.1 modeled as RSCENARIO_switch25_1 N001 0 1m
RSCENARIO_switch25_1 N001 0 1m
.op
.end
