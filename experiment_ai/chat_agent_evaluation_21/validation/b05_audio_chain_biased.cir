* Independent validation for b05: correctly biased two-stage audio-chain test
Vbattery2_1 0 N002 DC 9
Rbreaker3_1 N003 N004 2k
Ddiode7_1 N001 N005 D_GENERIC
Linductor10_1 N001 0 0.00025
Qnpn_transistor18_1 N007 N006 0 PNP_GENERIC
Qnpn_transistor18_2 N003 N008 0 PNP_GENERIC
Cpolarized_capacitor20_1 N001 0 375p
Cpolarized_capacitor20_2 N005 N006 0.022u
Cpolarized_capacitor20_3 N007 N008 0.022u
Cpolarized_capacitor20_4 N003 N004 0.001u
Rresistor22_1 N006 N004 220k
Rresistor22_2 N007 N004 4.7k
Rresistor22_3 N008 N004 220k
Rswitch_closed N002 N004 1m

* Preserve Q1 base bias measured in the powered base scenario and add 1 mVpk.
Vtest_N006 N006 0 SIN(-0.791174 1m 1k)
Eheadset OUT 0 N003 N004 1

.model D_GENERIC D
.model PNP_GENERIC PNP

.op
.tran 1us 5ms
.measure tran vin_pp PP v(N006) from=1ms to=5ms
.measure tran vq2base_pp PP v(N008) from=1ms to=5ms
.measure tran vout_pp PP v(OUT) from=1ms to=5ms
.measure tran gain param='vout_pp/vin_pp'
.end
